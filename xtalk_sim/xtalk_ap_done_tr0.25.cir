* HE-PCB crosstalk: bus=ap_done  len=2.764 in  gap=6.0 mil  N=40 segments
* Z0=28.4 ohm  tpd=135.3 ps/in  kL=0.0650 kC=0.0625  (victim between 2 aggressors)
*--- edit these to sweep edge-rate / data-rate ---
.param VDD=1.8
.param TR=0.25n        ; rise time (PRIMARY knob - crosstalk scales with this)
.param TF={TR}          ; fall time
.param PERIOD=10.0n  ; bit/clock period
.param PW={PERIOD/2-TR}   ; high time
.param RDRV=30.0        ; driver output impedance (ohm)
.param CLOAD=3.0p   ; receiver input capacitance
*--------------------------------------------------
VA1 na1_src 0 PULSE(0 {VDD} 1n {TR} {TF} {PW} {PERIOD})
VA2 na2_src 0 PULSE(0 {VDD} 1n {TR} {TF} {PW} {PERIOD})
RA1 na1_src a1_0 {RDRV}
RA2 na2_src a2_0 {RDRV}
RV  0 v_0 {RDRV}            ; victim driver holding LOW (source Z to gnd)
Ra1_0 a1_0 a1r_0 4.284479e-03
La1_0 a1r_0 a1_1 2.655943e-10
Rv_0 v_0 vr_0 4.284479e-03
Lv_0 vr_0 v_1 2.655943e-10
Ra2_0 a2_0 a2r_0 4.284479e-03
La2_0 a2r_0 a2_1 2.655943e-10
Kav1_0 La1_0 Lv_0 0.06500
Kav2_0 Lv_0 La2_0 0.06500
Ra1_1 a1_1 a1r_1 4.284479e-03
La1_1 a1r_1 a1_2 2.655943e-10
Rv_1 v_1 vr_1 4.284479e-03
Lv_1 vr_1 v_2 2.655943e-10
Ra2_1 a2_1 a2r_1 4.284479e-03
La2_1 a2r_1 a2_2 2.655943e-10
Kav1_1 La1_1 Lv_1 0.06500
Kav2_1 Lv_1 La2_1 0.06500
Ra1_2 a1_2 a1r_2 4.284479e-03
La1_2 a1r_2 a1_3 2.655943e-10
Rv_2 v_2 vr_2 4.284479e-03
Lv_2 vr_2 v_3 2.655943e-10
Ra2_2 a2_2 a2r_2 4.284479e-03
La2_2 a2r_2 a2_3 2.655943e-10
Kav1_2 La1_2 Lv_2 0.06500
Kav2_2 Lv_2 La2_2 0.06500
Ra1_3 a1_3 a1r_3 4.284479e-03
La1_3 a1r_3 a1_4 2.655943e-10
Rv_3 v_3 vr_3 4.284479e-03
Lv_3 vr_3 v_4 2.655943e-10
Ra2_3 a2_3 a2r_3 4.284479e-03
La2_3 a2r_3 a2_4 2.655943e-10
Kav1_3 La1_3 Lv_3 0.06500
Kav2_3 Lv_3 La2_3 0.06500
Ra1_4 a1_4 a1r_4 4.284479e-03
La1_4 a1r_4 a1_5 2.655943e-10
Rv_4 v_4 vr_4 4.284479e-03
Lv_4 vr_4 v_5 2.655943e-10
Ra2_4 a2_4 a2r_4 4.284479e-03
La2_4 a2r_4 a2_5 2.655943e-10
Kav1_4 La1_4 Lv_4 0.06500
Kav2_4 Lv_4 La2_4 0.06500
Ra1_5 a1_5 a1r_5 4.284479e-03
La1_5 a1r_5 a1_6 2.655943e-10
Rv_5 v_5 vr_5 4.284479e-03
Lv_5 vr_5 v_6 2.655943e-10
Ra2_5 a2_5 a2r_5 4.284479e-03
La2_5 a2r_5 a2_6 2.655943e-10
Kav1_5 La1_5 Lv_5 0.06500
Kav2_5 Lv_5 La2_5 0.06500
Ra1_6 a1_6 a1r_6 4.284479e-03
La1_6 a1r_6 a1_7 2.655943e-10
Rv_6 v_6 vr_6 4.284479e-03
Lv_6 vr_6 v_7 2.655943e-10
Ra2_6 a2_6 a2r_6 4.284479e-03
La2_6 a2r_6 a2_7 2.655943e-10
Kav1_6 La1_6 Lv_6 0.06500
Kav2_6 Lv_6 La2_6 0.06500
Ra1_7 a1_7 a1r_7 4.284479e-03
La1_7 a1r_7 a1_8 2.655943e-10
Rv_7 v_7 vr_7 4.284479e-03
Lv_7 vr_7 v_8 2.655943e-10
Ra2_7 a2_7 a2r_7 4.284479e-03
La2_7 a2r_7 a2_8 2.655943e-10
Kav1_7 La1_7 Lv_7 0.06500
Kav2_7 Lv_7 La2_7 0.06500
Ra1_8 a1_8 a1r_8 4.284479e-03
La1_8 a1r_8 a1_9 2.655943e-10
Rv_8 v_8 vr_8 4.284479e-03
Lv_8 vr_8 v_9 2.655943e-10
Ra2_8 a2_8 a2r_8 4.284479e-03
La2_8 a2r_8 a2_9 2.655943e-10
Kav1_8 La1_8 Lv_8 0.06500
Kav2_8 Lv_8 La2_8 0.06500
Ra1_9 a1_9 a1r_9 4.284479e-03
La1_9 a1r_9 a1_10 2.655943e-10
Rv_9 v_9 vr_9 4.284479e-03
Lv_9 vr_9 v_10 2.655943e-10
Ra2_9 a2_9 a2r_9 4.284479e-03
La2_9 a2r_9 a2_10 2.655943e-10
Kav1_9 La1_9 Lv_9 0.06500
Kav2_9 Lv_9 La2_9 0.06500
Ra1_10 a1_10 a1r_10 4.284479e-03
La1_10 a1r_10 a1_11 2.655943e-10
Rv_10 v_10 vr_10 4.284479e-03
Lv_10 vr_10 v_11 2.655943e-10
Ra2_10 a2_10 a2r_10 4.284479e-03
La2_10 a2r_10 a2_11 2.655943e-10
Kav1_10 La1_10 Lv_10 0.06500
Kav2_10 Lv_10 La2_10 0.06500
Ra1_11 a1_11 a1r_11 4.284479e-03
La1_11 a1r_11 a1_12 2.655943e-10
Rv_11 v_11 vr_11 4.284479e-03
Lv_11 vr_11 v_12 2.655943e-10
Ra2_11 a2_11 a2r_11 4.284479e-03
La2_11 a2r_11 a2_12 2.655943e-10
Kav1_11 La1_11 Lv_11 0.06500
Kav2_11 Lv_11 La2_11 0.06500
Ra1_12 a1_12 a1r_12 4.284479e-03
La1_12 a1r_12 a1_13 2.655943e-10
Rv_12 v_12 vr_12 4.284479e-03
Lv_12 vr_12 v_13 2.655943e-10
Ra2_12 a2_12 a2r_12 4.284479e-03
La2_12 a2r_12 a2_13 2.655943e-10
Kav1_12 La1_12 Lv_12 0.06500
Kav2_12 Lv_12 La2_12 0.06500
Ra1_13 a1_13 a1r_13 4.284479e-03
La1_13 a1r_13 a1_14 2.655943e-10
Rv_13 v_13 vr_13 4.284479e-03
Lv_13 vr_13 v_14 2.655943e-10
Ra2_13 a2_13 a2r_13 4.284479e-03
La2_13 a2r_13 a2_14 2.655943e-10
Kav1_13 La1_13 Lv_13 0.06500
Kav2_13 Lv_13 La2_13 0.06500
Ra1_14 a1_14 a1r_14 4.284479e-03
La1_14 a1r_14 a1_15 2.655943e-10
Rv_14 v_14 vr_14 4.284479e-03
Lv_14 vr_14 v_15 2.655943e-10
Ra2_14 a2_14 a2r_14 4.284479e-03
La2_14 a2r_14 a2_15 2.655943e-10
Kav1_14 La1_14 Lv_14 0.06500
Kav2_14 Lv_14 La2_14 0.06500
Ra1_15 a1_15 a1r_15 4.284479e-03
La1_15 a1r_15 a1_16 2.655943e-10
Rv_15 v_15 vr_15 4.284479e-03
Lv_15 vr_15 v_16 2.655943e-10
Ra2_15 a2_15 a2r_15 4.284479e-03
La2_15 a2r_15 a2_16 2.655943e-10
Kav1_15 La1_15 Lv_15 0.06500
Kav2_15 Lv_15 La2_15 0.06500
Ra1_16 a1_16 a1r_16 4.284479e-03
La1_16 a1r_16 a1_17 2.655943e-10
Rv_16 v_16 vr_16 4.284479e-03
Lv_16 vr_16 v_17 2.655943e-10
Ra2_16 a2_16 a2r_16 4.284479e-03
La2_16 a2r_16 a2_17 2.655943e-10
Kav1_16 La1_16 Lv_16 0.06500
Kav2_16 Lv_16 La2_16 0.06500
Ra1_17 a1_17 a1r_17 4.284479e-03
La1_17 a1r_17 a1_18 2.655943e-10
Rv_17 v_17 vr_17 4.284479e-03
Lv_17 vr_17 v_18 2.655943e-10
Ra2_17 a2_17 a2r_17 4.284479e-03
La2_17 a2r_17 a2_18 2.655943e-10
Kav1_17 La1_17 Lv_17 0.06500
Kav2_17 Lv_17 La2_17 0.06500
Ra1_18 a1_18 a1r_18 4.284479e-03
La1_18 a1r_18 a1_19 2.655943e-10
Rv_18 v_18 vr_18 4.284479e-03
Lv_18 vr_18 v_19 2.655943e-10
Ra2_18 a2_18 a2r_18 4.284479e-03
La2_18 a2r_18 a2_19 2.655943e-10
Kav1_18 La1_18 Lv_18 0.06500
Kav2_18 Lv_18 La2_18 0.06500
Ra1_19 a1_19 a1r_19 4.284479e-03
La1_19 a1r_19 a1_20 2.655943e-10
Rv_19 v_19 vr_19 4.284479e-03
Lv_19 vr_19 v_20 2.655943e-10
Ra2_19 a2_19 a2r_19 4.284479e-03
La2_19 a2r_19 a2_20 2.655943e-10
Kav1_19 La1_19 Lv_19 0.06500
Kav2_19 Lv_19 La2_19 0.06500
Ra1_20 a1_20 a1r_20 4.284479e-03
La1_20 a1r_20 a1_21 2.655943e-10
Rv_20 v_20 vr_20 4.284479e-03
Lv_20 vr_20 v_21 2.655943e-10
Ra2_20 a2_20 a2r_20 4.284479e-03
La2_20 a2r_20 a2_21 2.655943e-10
Kav1_20 La1_20 Lv_20 0.06500
Kav2_20 Lv_20 La2_20 0.06500
Ra1_21 a1_21 a1r_21 4.284479e-03
La1_21 a1r_21 a1_22 2.655943e-10
Rv_21 v_21 vr_21 4.284479e-03
Lv_21 vr_21 v_22 2.655943e-10
Ra2_21 a2_21 a2r_21 4.284479e-03
La2_21 a2r_21 a2_22 2.655943e-10
Kav1_21 La1_21 Lv_21 0.06500
Kav2_21 Lv_21 La2_21 0.06500
Ra1_22 a1_22 a1r_22 4.284479e-03
La1_22 a1r_22 a1_23 2.655943e-10
Rv_22 v_22 vr_22 4.284479e-03
Lv_22 vr_22 v_23 2.655943e-10
Ra2_22 a2_22 a2r_22 4.284479e-03
La2_22 a2r_22 a2_23 2.655943e-10
Kav1_22 La1_22 Lv_22 0.06500
Kav2_22 Lv_22 La2_22 0.06500
Ra1_23 a1_23 a1r_23 4.284479e-03
La1_23 a1r_23 a1_24 2.655943e-10
Rv_23 v_23 vr_23 4.284479e-03
Lv_23 vr_23 v_24 2.655943e-10
Ra2_23 a2_23 a2r_23 4.284479e-03
La2_23 a2r_23 a2_24 2.655943e-10
Kav1_23 La1_23 Lv_23 0.06500
Kav2_23 Lv_23 La2_23 0.06500
Ra1_24 a1_24 a1r_24 4.284479e-03
La1_24 a1r_24 a1_25 2.655943e-10
Rv_24 v_24 vr_24 4.284479e-03
Lv_24 vr_24 v_25 2.655943e-10
Ra2_24 a2_24 a2r_24 4.284479e-03
La2_24 a2r_24 a2_25 2.655943e-10
Kav1_24 La1_24 Lv_24 0.06500
Kav2_24 Lv_24 La2_24 0.06500
Ra1_25 a1_25 a1r_25 4.284479e-03
La1_25 a1r_25 a1_26 2.655943e-10
Rv_25 v_25 vr_25 4.284479e-03
Lv_25 vr_25 v_26 2.655943e-10
Ra2_25 a2_25 a2r_25 4.284479e-03
La2_25 a2r_25 a2_26 2.655943e-10
Kav1_25 La1_25 Lv_25 0.06500
Kav2_25 Lv_25 La2_25 0.06500
Ra1_26 a1_26 a1r_26 4.284479e-03
La1_26 a1r_26 a1_27 2.655943e-10
Rv_26 v_26 vr_26 4.284479e-03
Lv_26 vr_26 v_27 2.655943e-10
Ra2_26 a2_26 a2r_26 4.284479e-03
La2_26 a2r_26 a2_27 2.655943e-10
Kav1_26 La1_26 Lv_26 0.06500
Kav2_26 Lv_26 La2_26 0.06500
Ra1_27 a1_27 a1r_27 4.284479e-03
La1_27 a1r_27 a1_28 2.655943e-10
Rv_27 v_27 vr_27 4.284479e-03
Lv_27 vr_27 v_28 2.655943e-10
Ra2_27 a2_27 a2r_27 4.284479e-03
La2_27 a2r_27 a2_28 2.655943e-10
Kav1_27 La1_27 Lv_27 0.06500
Kav2_27 Lv_27 La2_27 0.06500
Ra1_28 a1_28 a1r_28 4.284479e-03
La1_28 a1r_28 a1_29 2.655943e-10
Rv_28 v_28 vr_28 4.284479e-03
Lv_28 vr_28 v_29 2.655943e-10
Ra2_28 a2_28 a2r_28 4.284479e-03
La2_28 a2r_28 a2_29 2.655943e-10
Kav1_28 La1_28 Lv_28 0.06500
Kav2_28 Lv_28 La2_28 0.06500
Ra1_29 a1_29 a1r_29 4.284479e-03
La1_29 a1r_29 a1_30 2.655943e-10
Rv_29 v_29 vr_29 4.284479e-03
Lv_29 vr_29 v_30 2.655943e-10
Ra2_29 a2_29 a2r_29 4.284479e-03
La2_29 a2r_29 a2_30 2.655943e-10
Kav1_29 La1_29 Lv_29 0.06500
Kav2_29 Lv_29 La2_29 0.06500
Ra1_30 a1_30 a1r_30 4.284479e-03
La1_30 a1r_30 a1_31 2.655943e-10
Rv_30 v_30 vr_30 4.284479e-03
Lv_30 vr_30 v_31 2.655943e-10
Ra2_30 a2_30 a2r_30 4.284479e-03
La2_30 a2r_30 a2_31 2.655943e-10
Kav1_30 La1_30 Lv_30 0.06500
Kav2_30 Lv_30 La2_30 0.06500
Ra1_31 a1_31 a1r_31 4.284479e-03
La1_31 a1r_31 a1_32 2.655943e-10
Rv_31 v_31 vr_31 4.284479e-03
Lv_31 vr_31 v_32 2.655943e-10
Ra2_31 a2_31 a2r_31 4.284479e-03
La2_31 a2r_31 a2_32 2.655943e-10
Kav1_31 La1_31 Lv_31 0.06500
Kav2_31 Lv_31 La2_31 0.06500
Ra1_32 a1_32 a1r_32 4.284479e-03
La1_32 a1r_32 a1_33 2.655943e-10
Rv_32 v_32 vr_32 4.284479e-03
Lv_32 vr_32 v_33 2.655943e-10
Ra2_32 a2_32 a2r_32 4.284479e-03
La2_32 a2r_32 a2_33 2.655943e-10
Kav1_32 La1_32 Lv_32 0.06500
Kav2_32 Lv_32 La2_32 0.06500
Ra1_33 a1_33 a1r_33 4.284479e-03
La1_33 a1r_33 a1_34 2.655943e-10
Rv_33 v_33 vr_33 4.284479e-03
Lv_33 vr_33 v_34 2.655943e-10
Ra2_33 a2_33 a2r_33 4.284479e-03
La2_33 a2r_33 a2_34 2.655943e-10
Kav1_33 La1_33 Lv_33 0.06500
Kav2_33 Lv_33 La2_33 0.06500
Ra1_34 a1_34 a1r_34 4.284479e-03
La1_34 a1r_34 a1_35 2.655943e-10
Rv_34 v_34 vr_34 4.284479e-03
Lv_34 vr_34 v_35 2.655943e-10
Ra2_34 a2_34 a2r_34 4.284479e-03
La2_34 a2r_34 a2_35 2.655943e-10
Kav1_34 La1_34 Lv_34 0.06500
Kav2_34 Lv_34 La2_34 0.06500
Ra1_35 a1_35 a1r_35 4.284479e-03
La1_35 a1r_35 a1_36 2.655943e-10
Rv_35 v_35 vr_35 4.284479e-03
Lv_35 vr_35 v_36 2.655943e-10
Ra2_35 a2_35 a2r_35 4.284479e-03
La2_35 a2r_35 a2_36 2.655943e-10
Kav1_35 La1_35 Lv_35 0.06500
Kav2_35 Lv_35 La2_35 0.06500
Ra1_36 a1_36 a1r_36 4.284479e-03
La1_36 a1r_36 a1_37 2.655943e-10
Rv_36 v_36 vr_36 4.284479e-03
Lv_36 vr_36 v_37 2.655943e-10
Ra2_36 a2_36 a2r_36 4.284479e-03
La2_36 a2r_36 a2_37 2.655943e-10
Kav1_36 La1_36 Lv_36 0.06500
Kav2_36 Lv_36 La2_36 0.06500
Ra1_37 a1_37 a1r_37 4.284479e-03
La1_37 a1r_37 a1_38 2.655943e-10
Rv_37 v_37 vr_37 4.284479e-03
Lv_37 vr_37 v_38 2.655943e-10
Ra2_37 a2_37 a2r_37 4.284479e-03
La2_37 a2r_37 a2_38 2.655943e-10
Kav1_37 La1_37 Lv_37 0.06500
Kav2_37 Lv_37 La2_37 0.06500
Ra1_38 a1_38 a1r_38 4.284479e-03
La1_38 a1r_38 a1_39 2.655943e-10
Rv_38 v_38 vr_38 4.284479e-03
Lv_38 vr_38 v_39 2.655943e-10
Ra2_38 a2_38 a2r_38 4.284479e-03
La2_38 a2r_38 a2_39 2.655943e-10
Kav1_38 La1_38 Lv_38 0.06500
Kav2_38 Lv_38 La2_38 0.06500
Ra1_39 a1_39 a1r_39 4.284479e-03
La1_39 a1r_39 a1_40 2.655943e-10
Rv_39 v_39 vr_39 4.284479e-03
Lv_39 vr_39 v_40 2.655943e-10
Ra2_39 a2_39 a2r_39 4.284479e-03
La2_39 a2r_39 a2_40 2.655943e-10
Kav1_39 La1_39 Lv_39 0.06500
Kav2_39 Lv_39 La2_39 0.06500
Ca1_1 a1_1 0 3.292927e-13
Cv_1 v_1 0 3.292927e-13
Ca2_1 a2_1 0 3.292927e-13
Cm1_1 a1_1 v_1 2.058079e-14
Cm2_1 v_1 a2_1 2.058079e-14
Ca1_2 a1_2 0 3.292927e-13
Cv_2 v_2 0 3.292927e-13
Ca2_2 a2_2 0 3.292927e-13
Cm1_2 a1_2 v_2 2.058079e-14
Cm2_2 v_2 a2_2 2.058079e-14
Ca1_3 a1_3 0 3.292927e-13
Cv_3 v_3 0 3.292927e-13
Ca2_3 a2_3 0 3.292927e-13
Cm1_3 a1_3 v_3 2.058079e-14
Cm2_3 v_3 a2_3 2.058079e-14
Ca1_4 a1_4 0 3.292927e-13
Cv_4 v_4 0 3.292927e-13
Ca2_4 a2_4 0 3.292927e-13
Cm1_4 a1_4 v_4 2.058079e-14
Cm2_4 v_4 a2_4 2.058079e-14
Ca1_5 a1_5 0 3.292927e-13
Cv_5 v_5 0 3.292927e-13
Ca2_5 a2_5 0 3.292927e-13
Cm1_5 a1_5 v_5 2.058079e-14
Cm2_5 v_5 a2_5 2.058079e-14
Ca1_6 a1_6 0 3.292927e-13
Cv_6 v_6 0 3.292927e-13
Ca2_6 a2_6 0 3.292927e-13
Cm1_6 a1_6 v_6 2.058079e-14
Cm2_6 v_6 a2_6 2.058079e-14
Ca1_7 a1_7 0 3.292927e-13
Cv_7 v_7 0 3.292927e-13
Ca2_7 a2_7 0 3.292927e-13
Cm1_7 a1_7 v_7 2.058079e-14
Cm2_7 v_7 a2_7 2.058079e-14
Ca1_8 a1_8 0 3.292927e-13
Cv_8 v_8 0 3.292927e-13
Ca2_8 a2_8 0 3.292927e-13
Cm1_8 a1_8 v_8 2.058079e-14
Cm2_8 v_8 a2_8 2.058079e-14
Ca1_9 a1_9 0 3.292927e-13
Cv_9 v_9 0 3.292927e-13
Ca2_9 a2_9 0 3.292927e-13
Cm1_9 a1_9 v_9 2.058079e-14
Cm2_9 v_9 a2_9 2.058079e-14
Ca1_10 a1_10 0 3.292927e-13
Cv_10 v_10 0 3.292927e-13
Ca2_10 a2_10 0 3.292927e-13
Cm1_10 a1_10 v_10 2.058079e-14
Cm2_10 v_10 a2_10 2.058079e-14
Ca1_11 a1_11 0 3.292927e-13
Cv_11 v_11 0 3.292927e-13
Ca2_11 a2_11 0 3.292927e-13
Cm1_11 a1_11 v_11 2.058079e-14
Cm2_11 v_11 a2_11 2.058079e-14
Ca1_12 a1_12 0 3.292927e-13
Cv_12 v_12 0 3.292927e-13
Ca2_12 a2_12 0 3.292927e-13
Cm1_12 a1_12 v_12 2.058079e-14
Cm2_12 v_12 a2_12 2.058079e-14
Ca1_13 a1_13 0 3.292927e-13
Cv_13 v_13 0 3.292927e-13
Ca2_13 a2_13 0 3.292927e-13
Cm1_13 a1_13 v_13 2.058079e-14
Cm2_13 v_13 a2_13 2.058079e-14
Ca1_14 a1_14 0 3.292927e-13
Cv_14 v_14 0 3.292927e-13
Ca2_14 a2_14 0 3.292927e-13
Cm1_14 a1_14 v_14 2.058079e-14
Cm2_14 v_14 a2_14 2.058079e-14
Ca1_15 a1_15 0 3.292927e-13
Cv_15 v_15 0 3.292927e-13
Ca2_15 a2_15 0 3.292927e-13
Cm1_15 a1_15 v_15 2.058079e-14
Cm2_15 v_15 a2_15 2.058079e-14
Ca1_16 a1_16 0 3.292927e-13
Cv_16 v_16 0 3.292927e-13
Ca2_16 a2_16 0 3.292927e-13
Cm1_16 a1_16 v_16 2.058079e-14
Cm2_16 v_16 a2_16 2.058079e-14
Ca1_17 a1_17 0 3.292927e-13
Cv_17 v_17 0 3.292927e-13
Ca2_17 a2_17 0 3.292927e-13
Cm1_17 a1_17 v_17 2.058079e-14
Cm2_17 v_17 a2_17 2.058079e-14
Ca1_18 a1_18 0 3.292927e-13
Cv_18 v_18 0 3.292927e-13
Ca2_18 a2_18 0 3.292927e-13
Cm1_18 a1_18 v_18 2.058079e-14
Cm2_18 v_18 a2_18 2.058079e-14
Ca1_19 a1_19 0 3.292927e-13
Cv_19 v_19 0 3.292927e-13
Ca2_19 a2_19 0 3.292927e-13
Cm1_19 a1_19 v_19 2.058079e-14
Cm2_19 v_19 a2_19 2.058079e-14
Ca1_20 a1_20 0 3.292927e-13
Cv_20 v_20 0 3.292927e-13
Ca2_20 a2_20 0 3.292927e-13
Cm1_20 a1_20 v_20 2.058079e-14
Cm2_20 v_20 a2_20 2.058079e-14
Ca1_21 a1_21 0 3.292927e-13
Cv_21 v_21 0 3.292927e-13
Ca2_21 a2_21 0 3.292927e-13
Cm1_21 a1_21 v_21 2.058079e-14
Cm2_21 v_21 a2_21 2.058079e-14
Ca1_22 a1_22 0 3.292927e-13
Cv_22 v_22 0 3.292927e-13
Ca2_22 a2_22 0 3.292927e-13
Cm1_22 a1_22 v_22 2.058079e-14
Cm2_22 v_22 a2_22 2.058079e-14
Ca1_23 a1_23 0 3.292927e-13
Cv_23 v_23 0 3.292927e-13
Ca2_23 a2_23 0 3.292927e-13
Cm1_23 a1_23 v_23 2.058079e-14
Cm2_23 v_23 a2_23 2.058079e-14
Ca1_24 a1_24 0 3.292927e-13
Cv_24 v_24 0 3.292927e-13
Ca2_24 a2_24 0 3.292927e-13
Cm1_24 a1_24 v_24 2.058079e-14
Cm2_24 v_24 a2_24 2.058079e-14
Ca1_25 a1_25 0 3.292927e-13
Cv_25 v_25 0 3.292927e-13
Ca2_25 a2_25 0 3.292927e-13
Cm1_25 a1_25 v_25 2.058079e-14
Cm2_25 v_25 a2_25 2.058079e-14
Ca1_26 a1_26 0 3.292927e-13
Cv_26 v_26 0 3.292927e-13
Ca2_26 a2_26 0 3.292927e-13
Cm1_26 a1_26 v_26 2.058079e-14
Cm2_26 v_26 a2_26 2.058079e-14
Ca1_27 a1_27 0 3.292927e-13
Cv_27 v_27 0 3.292927e-13
Ca2_27 a2_27 0 3.292927e-13
Cm1_27 a1_27 v_27 2.058079e-14
Cm2_27 v_27 a2_27 2.058079e-14
Ca1_28 a1_28 0 3.292927e-13
Cv_28 v_28 0 3.292927e-13
Ca2_28 a2_28 0 3.292927e-13
Cm1_28 a1_28 v_28 2.058079e-14
Cm2_28 v_28 a2_28 2.058079e-14
Ca1_29 a1_29 0 3.292927e-13
Cv_29 v_29 0 3.292927e-13
Ca2_29 a2_29 0 3.292927e-13
Cm1_29 a1_29 v_29 2.058079e-14
Cm2_29 v_29 a2_29 2.058079e-14
Ca1_30 a1_30 0 3.292927e-13
Cv_30 v_30 0 3.292927e-13
Ca2_30 a2_30 0 3.292927e-13
Cm1_30 a1_30 v_30 2.058079e-14
Cm2_30 v_30 a2_30 2.058079e-14
Ca1_31 a1_31 0 3.292927e-13
Cv_31 v_31 0 3.292927e-13
Ca2_31 a2_31 0 3.292927e-13
Cm1_31 a1_31 v_31 2.058079e-14
Cm2_31 v_31 a2_31 2.058079e-14
Ca1_32 a1_32 0 3.292927e-13
Cv_32 v_32 0 3.292927e-13
Ca2_32 a2_32 0 3.292927e-13
Cm1_32 a1_32 v_32 2.058079e-14
Cm2_32 v_32 a2_32 2.058079e-14
Ca1_33 a1_33 0 3.292927e-13
Cv_33 v_33 0 3.292927e-13
Ca2_33 a2_33 0 3.292927e-13
Cm1_33 a1_33 v_33 2.058079e-14
Cm2_33 v_33 a2_33 2.058079e-14
Ca1_34 a1_34 0 3.292927e-13
Cv_34 v_34 0 3.292927e-13
Ca2_34 a2_34 0 3.292927e-13
Cm1_34 a1_34 v_34 2.058079e-14
Cm2_34 v_34 a2_34 2.058079e-14
Ca1_35 a1_35 0 3.292927e-13
Cv_35 v_35 0 3.292927e-13
Ca2_35 a2_35 0 3.292927e-13
Cm1_35 a1_35 v_35 2.058079e-14
Cm2_35 v_35 a2_35 2.058079e-14
Ca1_36 a1_36 0 3.292927e-13
Cv_36 v_36 0 3.292927e-13
Ca2_36 a2_36 0 3.292927e-13
Cm1_36 a1_36 v_36 2.058079e-14
Cm2_36 v_36 a2_36 2.058079e-14
Ca1_37 a1_37 0 3.292927e-13
Cv_37 v_37 0 3.292927e-13
Ca2_37 a2_37 0 3.292927e-13
Cm1_37 a1_37 v_37 2.058079e-14
Cm2_37 v_37 a2_37 2.058079e-14
Ca1_38 a1_38 0 3.292927e-13
Cv_38 v_38 0 3.292927e-13
Ca2_38 a2_38 0 3.292927e-13
Cm1_38 a1_38 v_38 2.058079e-14
Cm2_38 v_38 a2_38 2.058079e-14
Ca1_39 a1_39 0 3.292927e-13
Cv_39 v_39 0 3.292927e-13
Ca2_39 a2_39 0 3.292927e-13
Cm1_39 a1_39 v_39 2.058079e-14
Cm2_39 v_39 a2_39 2.058079e-14
Ca1_40 a1_40 0 3.292927e-13
Cv_40 v_40 0 3.292927e-13
Ca2_40 a2_40 0 3.292927e-13
Cm1_40 a1_40 v_40 2.058079e-14
Cm2_40 v_40 a2_40 2.058079e-14
CLa1 a1_40 0 {CLOAD}
CLv  v_40 0 {CLOAD}
CLa2 a2_40 0 {CLOAD}
.tran 0 {4*PERIOD} 0 {TR/20}
.meas TRAN aggr_swing PP V(a1_0)
.meas TRAN next_pos MAX V(v_0)
.meas TRAN next_neg MIN V(v_0)
.meas TRAN next_pk  MAX abs(V(v_0))
.meas TRAN fext_pk  MAX abs(V(v_40))
.end
